* Buffer I/O subcircuit
* NgSPICE version for testing

.include "models/nmos.cir"
.include "models/pmos.cir"

.subckt buf_io pad vdd vss din en wp=2u wn=1u

* Pull-up PMOS
Mp0 pad din_b vdd vdd pmos w=wp l=100n

* Pull-down NMOS
Mn0 pad din_i vss vss nmos w=wn l=100n

* Enable logic
Mn1 din_i din en_i vss nmos w=wn l=100n
Mp1 din_b din vdd vdd pmos w=wp l=100n

* Tristate control
Mn_en en_i en vss vss nmos w=500n l=100n

.ends buf_io
