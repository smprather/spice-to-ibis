* NMOS Level 1 model for testing
* Simplified Shichman-Hodges model (180nm-like parameters)
.model nmos nmos level=1 vto=0.4 kp=200u gamma=0.4 phi=0.65
